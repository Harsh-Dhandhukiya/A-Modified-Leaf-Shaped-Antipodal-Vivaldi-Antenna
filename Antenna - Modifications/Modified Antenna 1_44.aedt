# Ansys Electronics Desktop project, version 2024.2
materials:
  vacuum: permittivity=1
  FR4_epoxy: permittivity=4.4 dielectric_loss_tangent=0.02

design HFSSDesign1 (HFSS, HFSS Modal Network, model units mm)
variables:
  W = 24.8mm
  L = 25mm
  Lg = 15mm
  Wg = 11mm
  Lf = 7.5mm
  Wd = 2.8mm
  Ld = 0.8mm
  Wf = 6.5mm
  h = 1.6mm
geometry:
  Circle1 = circle(normal=Z, centre=(0mm, 0mm, 0mm), radius=Wg+Wd)
  TopLeaf = rectangle(corner=(0mm, 0mm, 0mm), x_size=W, y_size=Lg-(Ld*2))
  TopLeaf.intersect(Circle1)
  TopSupport = rectangle(corner=(Wg, -Lf, 0mm), x_size=Wd, y_size=Lf)
  TopBase = rectangle(corner=(Wg-Wf+Wd, -Lf, 0mm), x_size=Wf, y_size=ld)
  BottomLeaf = rectangle(corner=(0, 0mm, -h*2), x_size=W, y_size=Lg-(Ld*2))
  Circle2 = circle(normal=Z, centre=(W, 0mm, -h*2), radius=Wg+Wd)
  BottomLeaf.intersect(Circle2)
  BottonSupport = rectangle(corner=(Wg, -Lf, -h*2), x_size=Wd, y_size=Lf)
  BottomBase = rectangle(corner=(Wg, -Lf, -h*2), x_size=Wf, y_size=ld)
  grd = rectangle(corner=(0mm, -((Lg-(Ld*2)+Lf) - (lg - (Ld*2))), -h), x_size=W, y_size=Lg-(Ld*2)+Lf)
  Box1 [FR4_epoxy] = box(corner=(0mm, -((Lg-(Ld*2)+Lf) - (lg - (Ld*2))), -h), size=(W, Lg-(Ld*2)+Lf, h))
  Box2 [FR4_epoxy] = box(corner=(0mm, -((Lg-(Ld*2)+Lf) - (lg - (Ld*2))), -h*2), size=(W, Lg-(Ld*2)+Lf, h))
  BottomBase.unite(BottomLeaf, BottonSupport)
  TopBase.unite(TopLeaf, TopSupport)
  Rectangle1 = rectangle(corner=(13.8mm, -7.5mm, 0mm), z_size=-1.6mm, x_size=-2.8mm)
  Rectangle2 = rectangle(corner=(11mm, -7.5mm, -1.6mm), z_size=-1.6mm, x_size=2.8mm)
  coordinate_system RelativeCS1 = origin=(12.4mm, -7.5mm, -3.2mm) x=(1mm, 0mm, 0mm) y=(0mm, 1mm, 0mm)
  coordinate_system RelativeCS2 = origin=(0mm, 0mm, 3.2mm) x=(1mm, 0mm, 0mm) y=(0mm, 1mm, 0mm) in RelativeCS1
  SMA_Connector1 = component(SMA_Connector, 3D_Component_File_Path="C:/Users/Harsh H/Desktop/SMA Connector/SMA_Connector - 3D Model.a3dcomp", pinD=0.36mm, outL=4mm, SX=7.35mm, in=0.43mm, SY=2.5mm, outD=2.6mm, TefD=2.2mm, pinL=1.5mm, subH=3.2mm)
  SMA_Body, arm1, arm2, arm1_1, arm2_1, Centar_pin, inner_pin [pec] = part_of(SMA_Connector1) in RelativeCS2
  outer_Cond [vacuum] = part_of(SMA_Connector1) in RelativeCS2
  Teflon [Teflon (tm)] = part_of(SMA_Connector1) in RelativeCS2
  inner_Cond [pec] = part_of(SMA_Connector1) in RelativeCS2
  Radiation_Box [vacuum] = box(corner=(-20mm, -13mm, -20mm), size=(40mm, 40mm, 40mm)) in RelativeCS2
boundaries and excitations:
  PerfE3: Perfect E Objects=TopBase
  PerfE6: Perfect E Objects=BottomBase
  PerfE7: Perfect E Objects=grd
  Rad1: Radiation Objects=Radiation_Box
  1: Lumped Port Objects=Rectangle1 LumpedPortType=Modal Modes{Mode1{IntLine{(12.4, -7.5, -1.6) -> (12.4, -7.5, 0)} CharImp=Zpi RenormImp=50ohm}} Impedance=50ohm
  2: Lumped Port Objects=Rectangle2 LumpedPortType=Modal Modes{Mode1{IntLine{(12.4, -7.5, -1.6) -> (12.4, -7.5, -3.2)} CharImp=Zpi RenormImp=50ohm}} Impedance=50ohm
setups:
  Setup1: HfssDriven MultipleAdaptiveFreqsSetup{AdaptAt{Frequency=2.4GHz Delta=0.02} AdaptAt{Frequency=7.7GHz Delta=0.02} AdaptAt{Frequency=10.6GHz Delta=0.02}} MaximumPasses=6 MinimumPasses=1 MinimumConvergedPasses=1 PercentRefinement=30 BasisOrder=1 PortAccuracy=2 DrivenSolverType="Direct Solver"
    sweep Sweep: 1GHz to 13GHz, 121 points; Type=Discrete SaveFields
source amplitudes:
  1:1: 1W 0deg
  2:1: 0W 0deg
reports:
  S Parameter Plot 1: dB(S(1,1)) vs Freq on Setup1 : Sweep
